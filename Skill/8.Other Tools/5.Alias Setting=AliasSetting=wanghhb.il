defun(AliasSetting ()
let((L_Alias)
	L_Alias = '()
	foreach(n0 axlGetAlias(nil)
		L_Alias = append1(L_Alias list(n0 axlGetAlias(n0)))

	)
	if()

)
)
